* funcs_neg: built-in functions on negative arguments
v1 1 0 1
rsqrt 1 0 '10+sqrt(-4)'
rlog 1 0 '10+log(-100)'
rlog10 1 0 '10+log10(-100)'
.op
.end
