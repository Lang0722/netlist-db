* brace_fn_unquoted: {...} without quotes in a source-function argument
.option list
.param a=0.5
V1 1 0 PWL(0 {a} 1n 1)
r1 1 0 1k
.op
.end
