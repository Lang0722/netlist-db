* hier_model_callee: an X line whose callee is the name of an R model card; no .hdl line
.model rmod r
v1 1 0 1
x1 1 t1 rmod
rt1 t1 0 1
r2 1 0 1k
.op
.end
