title_plus_words probe deck
+ more title words
v1 1 0 1
r2 1 0 2
.op
.end
