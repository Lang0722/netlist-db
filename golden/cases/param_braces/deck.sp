* param_braces: {...} in a .param value and in an element value
.param a=2 c={3*a}
v1 1 0 1
R1 1 0 {c}
.op
.end
