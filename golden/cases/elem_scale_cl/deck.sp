* elem_scale_cl: the element SCALE of C and L (.option list)
.option list
v1 1 0 1
c1 1 0 1p scale=3
l1 1 2 1n scale=3
r2 2 0 1k
.op
.end
