* end_in_include: .end between two R lines of an included file
v1 1 0 1
.op
.include 'inc.sp'
r3 1 0 3k
.end
