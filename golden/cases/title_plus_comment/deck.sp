* title_plus_comment: line 1 is a comment, line 2 is a + line
+ r9 1 0 9
v1 1 0 1
r2 1 0 2
.op
.end
