* dollar_func_body: a $ inside the quoted body of a .param function
.param f(x)='x*2 $ c'
v1 1 0 1
r1 1 0 'f(1)*1k'
r2 1 0 3k
.op
.end
