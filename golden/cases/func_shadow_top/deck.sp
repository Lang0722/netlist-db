* func_shadow_top: a top-level .param function with the name of a built-in function
.param max(a,b)='a+b'
v1 1 0 1
r1 1 0 'max(1,2)*1k'
r2 2 0 3k
v2 2 0 1
.op
.end
