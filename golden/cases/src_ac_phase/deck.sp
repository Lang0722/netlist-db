* src_ac_phase: a nonzero AC phase after the AC magnitude
.option list
V1 1 0 1.2 AC 1 45
V2 2 0 DC 0.5 AC 2 90
r1 1 0 1k
r2 2 0 1k
.op
.end
