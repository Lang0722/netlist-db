* param_braces_param: {...} in a .param value only
.param a=2 c={3*a}
v1 1 0 1
R1 1 0 c
.op
.end
