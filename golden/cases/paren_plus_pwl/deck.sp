* paren_plus_pwl: PWL values in parentheses that go on on a + line
.option list
v1 1 0 PWL(0 0.3
+ 1n 1)
r1 1 0 1k
.op
.end
