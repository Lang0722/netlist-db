* quote_tail_param: text after the closing quote of a .param value
.param a=2k
.param b='a' * 2
v1 1 0 1
r1 1 0 b
.op
.end
