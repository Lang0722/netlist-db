* funcs_extra: more HSPICE built-in functions (not in the netlist-expr minimum set)
v1 1 0 1
rnint 1 0 'nint(2.5)'
rfloor 1 0 'floor(2.7)'
rceil 1 0 'ceil(2.2)'
rsin 1 0 '10+sin(1)'
rcos 1 0 '10+cos(1)'
rtan 1 0 '10+tan(1)'
rasin 1 0 '10+asin(0.5)'
racos 1 0 '10+acos(0.5)'
ratan 1 0 '10+atan(1)'
rsinh 1 0 '10+sinh(1)'
rcosh 1 0 '10+cosh(1)'
rtanh 1 0 '10+tanh(1)'
rdb 1 0 '10+db(10)'
.op
.end
