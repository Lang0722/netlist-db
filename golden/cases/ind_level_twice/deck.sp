* probe_ind_level_twice: an l model card with level=3, then level=1
.model lmod l level=3 level=1
v1 1 0 1
L1 1 2 1n lmod
r1 2 0 1k
.op
.end
