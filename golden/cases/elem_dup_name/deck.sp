* elem_dup_name: two resistor lines with one name at the top level
v1 1 0 1
r1 1 0 1k
r1 1 0 2k
.op
.end
