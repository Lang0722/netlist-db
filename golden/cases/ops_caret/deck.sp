* ops_caret: is ^ the power operator? associativity and precedence
v1 1 0 1
r1 1 0 '2^3'
r2 1 0 '2^3^2'
r3 1 0 '-2^2+10'
r4 1 0 '2*3^2'
.op
.end
