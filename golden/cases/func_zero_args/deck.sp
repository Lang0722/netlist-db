* func_zero_args: a .param function with no arguments, not called
.param f0()='2'
v1 1 0 1
r1 1 0 1k
.op
.end
