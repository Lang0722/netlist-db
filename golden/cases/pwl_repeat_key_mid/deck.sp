* pwl_repeat_key_mid: PWL R= at a middle time point, alone
.option list
V1 1 0 PWL(0 0.3 1n 1 2n 0.5) R=1n
r1 1 0 1k
.op
.end
