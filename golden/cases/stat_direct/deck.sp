* stat_direct: agauss used directly in an element value (not through a .param)
v1 1 0 1
rd 1 0 'agauss(5k,0.1k,3)'
.op
.end
