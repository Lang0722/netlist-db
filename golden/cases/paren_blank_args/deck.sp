* paren_blank_args: a blank line inside the argument list of a .param function
.param g(x,

+ y)='x+y'
v1 1 0 1
r1 1 0 'g(1k,2k)'
.op
.end
