* kw_value_next_line: a key= at the end of a line, with its value on the next + line
v1 1 0 1
r1 1 0 r=
+ 5k
rc 1 0 1k
.op
.end
