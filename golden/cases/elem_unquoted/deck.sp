* elem_unquoted: an unquoted expression in the R value place
.param a=2k
v1 1 0 1
re 1 0 a*2
rc 1 0 1k
.op
.end
