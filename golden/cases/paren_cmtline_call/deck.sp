* paren_cmtline_call: a * comment line inside the parentheses of an unquoted function call in a .param value
.param p=max(1k,
* a comment line
+ 3k)
v1 1 0 1
rp 1 0 p
.op
.end
