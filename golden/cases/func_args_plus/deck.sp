* func_args_plus: the argument list of a .param function goes on on a + line
.param g(x,
+ y)='x+y'
v1 1 0 1
r1 1 0 'g(1k,2k)'
r2 1 0 2k
.op
.end
