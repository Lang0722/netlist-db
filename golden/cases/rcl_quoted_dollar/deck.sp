* rcl_quoted_dollar: a $ comment inside a quoted R value that goes on on a + line
.param rval=2k
v1 1 0 1
r1 1 0 'rval $ c
+ *2'
r2 1 0 3k
.op
.end
