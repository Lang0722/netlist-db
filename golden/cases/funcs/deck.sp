* funcs: built-in functions and a two-argument .param function
.param f(a,b)='a*b+1'
v1 1 0 1
rsqrt 1 0 'sqrt(4)'
rpow 1 0 'pow(2,3)'
rpown 1 0 '10+pow(-2,3)'
rpowf 1 0 'pow(2,0.5)'
rpowt 1 0 'pow(2,2.7)'
rpwr 1 0 '10+pwr(-2,2)'
rpwrf 1 0 '10+pwr(-2,0.5)'
rlog 1 0 'log(100)'
rlog10 1 0 'log10(100)'
rexp0 1 0 'exp(0)'
rexp 1 0 'exp(1)'
rabs 1 0 'abs(-1)'
rmin 1 0 'min(1,2)'
rmax 1 0 'max(1,2)'
rint 1 0 'int(2.7)'
rintn 1 0 '10+int(-2.7)'
rsgn 1 0 '10+sgn(-3)'
rsign 1 0 '10+sign(3,-1)'
rf 1 0 'f(2,3)'
.op
.end
