* ops: operator precedence, associativity, unary minus, comparisons, logic, ternary
v1 1 0 1
r1 1 0 '2+3*4'
r2 1 0 '2**3**2'
r3 1 0 '10-2**2'
r4 1 0 '-2**2+10'
r5 1 0 '(1+2)*3'
r6 1 0 '8/2/2'
r7 1 0 '10-3-2'
r8 1 0 '2*-3+10'
r9 1 0 '10+(1<2)'
r10 1 0 '10+(1<2 && 3>2)'
r11 1 0 '10+(0||0)'
r12 1 0 '1?2:3'
r13 1 0 '10+(2>=2)+(2<=1)'
r14 1 0 '10+(2==2)'
r15 1 0 '10+(2!=2)'
r16 1 0 '0?2:3'
r17 1 0 '1+1>1?5:6'
r18 1 0 '+3'
r19 1 0 '2*3**2'
r20 1 0 '10+(1||0&&0)'
r21 1 0 '1?2:0?4:5'
r22 1 0 '2**0.5'
r23 1 0 '10+(-2)**3'
.op
.end
