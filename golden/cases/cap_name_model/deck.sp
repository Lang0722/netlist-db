* cap_name_model: a parameter name in the C value place, then a model name
.option list
.model cmod c
.param cval=1p
c1 1 0 cval cmod
r1 1 0 1k
v1 1 0 1
.op
.end
