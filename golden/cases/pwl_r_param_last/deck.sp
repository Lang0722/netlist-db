* pwl_r_param_last: a parameter named r as the last PWL value, no parentheses
.option list
.param r=2
V1 1 0 PWL 0 0.3 1n r
r1 1 0 1k
.op
.end
