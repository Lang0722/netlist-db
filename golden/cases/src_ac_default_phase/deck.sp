* src_ac_default_phase: AC magnitude with no phase
.option list
V1 1 0 DC 1 AC 1
r1 1 0 1k
.op
.end
