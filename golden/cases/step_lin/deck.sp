* step_lin: a .step lin line
.param pv=2k
v1 1 0 1
r1 1 0 pv
r2 1 0 3k
.step lin pv 1k 3k 1k
.op
.end
