* sffm_phase: SFFM with 7 arguments (phasec, phases), no DC value
.option list
v1 1 0 SFFM(0.1 1 1meg 2 1k 90 0)
v2 2 0 SFFM(0.1 1 1meg 2 1k 0 90)
r1 1 0 1k
r2 2 0 1k
.op
.end
