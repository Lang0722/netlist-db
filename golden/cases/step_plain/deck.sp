* step_plain: a .step line without param
.param pv=2k
v1 1 0 1
r1 1 0 pv
r2 1 0 3k
.step pv 1k 3k 1k
.op
.end
