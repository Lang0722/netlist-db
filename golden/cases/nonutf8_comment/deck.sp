* nonutf8_comment: a Latin-1 byte (0xE9) inside a * comment
* café latin-1 comment
v1 1 0 1
r1 1 0 2k
.op
.end
