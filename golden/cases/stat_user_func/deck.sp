* probe_stat_user_func: a .param function named unif, called in an R value
.param unif(a,b)='(a+b)/2'
v1 1 0 1
r1 1 0 'unif(1k,3k)'
.op
.end
