* paren_blank_pwl: a blank line inside the parentheses of a PWL
.option list
v1 1 0 PWL(0 0.3

+ 1n 1)
r1 1 0 1k
.op
.end
