* brace_quoted_temp: {...} inside quotes in a .temp value
.param a=50
.temp '{a}'
v1 1 0 1
R1 1 0 1k
.op
.end
