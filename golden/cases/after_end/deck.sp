* after_end: element and .param lines after .end
.param p=1k
v1 1 0 1
r1 1 0 p
.op
.end
r9 1 0 9
.param p=2k
r8 1 0 p
