* lib_corner: .lib section selection (tt)
.lib 'models.lib' tt
v1 1 0 1
r1 1 0 rcorner
r2 1 0 rbase
.op
.end
