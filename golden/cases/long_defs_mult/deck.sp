* long_defs_mult: m= with engineering suffixes, long definition names, 3-digit circuit numbers
v1 1 0 1
.subckt c a b
rc a b 1k
.ends
.subckt very_long_definition_name_abcdef a b
rverylongname_x a b 7
.ends
xc0 1 n1 c
xc1 n1 n2 c
xc2 n2 n3 c
xc3 n3 n4 c
xc4 n4 n5 c
xc5 n5 n6 c
xc6 n6 n7 c
xc7 n7 n8 c
xc8 n8 n9 c
xc9 n9 n10 c
xc10 n10 n11 c
xc11 n11 n12 c
xc12 n12 n13 c
xc13 n13 n14 c
xc14 n14 n15 c
xc15 n15 n16 c
xc16 n16 n17 c
xc17 n17 n18 c
xc18 n18 n19 c
xc19 n19 n20 c
xc20 n20 n21 c
xc21 n21 n22 c
xc22 n22 n23 c
xc23 n23 n24 c
xc24 n24 n25 c
xc25 n25 n26 c
xc26 n26 n27 c
xc27 n27 n28 c
xc28 n28 n29 c
xc29 n29 n30 c
xc30 n30 n31 c
xc31 n31 n32 c
xc32 n32 n33 c
xc33 n33 n34 c
xc34 n34 n35 c
xc35 n35 n36 c
xc36 n36 n37 c
xc37 n37 n38 c
xc38 n38 n39 c
xc39 n39 n40 c
xc40 n40 n41 c
xc41 n41 n42 c
xc42 n42 n43 c
xc43 n43 n44 c
xc44 n44 n45 c
xc45 n45 n46 c
xc46 n46 n47 c
xc47 n47 n48 c
xc48 n48 n49 c
xc49 n49 n50 c
xc50 n50 n51 c
xc51 n51 n52 c
xc52 n52 n53 c
xc53 n53 n54 c
xc54 n54 n55 c
xc55 n55 n56 c
xc56 n56 n57 c
xc57 n57 n58 c
xc58 n58 n59 c
xc59 n59 n60 c
xc60 n60 n61 c
xc61 n61 n62 c
xc62 n62 n63 c
xc63 n63 n64 c
xc64 n64 n65 c
xc65 n65 n66 c
xc66 n66 n67 c
xc67 n67 n68 c
xc68 n68 n69 c
xc69 n69 n70 c
xc70 n70 n71 c
xc71 n71 n72 c
xc72 n72 n73 c
xc73 n73 n74 c
xc74 n74 n75 c
xc75 n75 n76 c
xc76 n76 n77 c
xc77 n77 n78 c
xc78 n78 n79 c
xc79 n79 n80 c
xc80 n80 n81 c
xc81 n81 n82 c
xc82 n82 n83 c
xc83 n83 n84 c
xc84 n84 n85 c
xc85 n85 n86 c
xc86 n86 n87 c
xc87 n87 n88 c
xc88 n88 n89 c
xc89 n89 n90 c
xc90 n90 n91 c
xc91 n91 n92 c
xc92 n92 n93 c
xc93 n93 n94 c
xc94 n94 n95 c
xc95 n95 n96 c
xc96 n96 n97 c
xc97 n97 n98 c
xc98 n98 n99 c
xc99 n99 0 c
xk 1 nk c m=1000
rk nk 0 1k
xh 1 nh c m=0.5
rh nh 0 1k
xmeg 1 nmeg c m=1meg
rmeg nmeg 0 1k
xd 1 nd very_long_definition_name_abcdef
rd nd 0 1k
xdk 1 ndk very_long_definition_name_abcdef m=1000
rdk ndk 0 1k
xtop_instance_name_very_long_123456789 1 nt very_long_definition_name_abcdef m=0.5
rt nt 0 1k
xtop_instance_name_very_long_12345678b 1 nb c m=2k
rb nb 0 1k
.op
.end
