* ops_not: unary logical not
v1 1 0 1
r1 1 0 '10+!0'
r2 1 0 '10+!3'
.op
.end
