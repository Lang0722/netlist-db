r1 1 0 1
+ r9 1 0 9
v1 1 0 1
r2 1 0 2
.op
.end
