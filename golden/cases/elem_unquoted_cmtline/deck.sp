* elem_unquoted_cmtline: an unquoted element expression, and a comment line inside a quoted value
.param a=2k
v1 1 0 1
re 1 0 a*2
r7 1 0 'a
* it's a comment line
+ *5'
rc 1 0 1k
.op
.end
