* pwl_repeat_noparen: PWL without parentheses, then R
.option list
V1 1 0 PWL 0 0.3 1n 1 R
r1 1 0 1k
.op
.end
