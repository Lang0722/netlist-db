* paren_cmtline_pwl: a * comment line inside the parentheses of a PWL
.option list
v1 1 0 PWL(0 0.3
* a comment line
+ 1n 1)
r1 1 0 1k
.op
.end
