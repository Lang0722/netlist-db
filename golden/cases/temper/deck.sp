* temper: temper in expressions with .temp 50
.temp 50
.param pt='100+temper'
v1 1 0 1
r1 1 0 '100+temper'
r2 1 0 pt
.op
.end
