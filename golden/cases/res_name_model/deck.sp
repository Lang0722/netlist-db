* res_name_model: a parameter name in the R value place, then a model name
.model rmod r
.param rval=2k
r1 1 0 rval rmod
v1 1 0 1
.op
.end
