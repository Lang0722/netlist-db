* src_fn_dc_more_noparen: DC after a PULSE function without parentheses
.option list
V1 1 0 PULSE 0 1 0 1n 1n 5n 10n DC 0.7
r1 1 0 1k
.op
.end
