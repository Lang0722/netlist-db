* dollar_elem_line: a $ inside a quoted R value on one line
.param rval=2k
v1 1 0 1
r1 1 0 'rval*3 $ c'
r2 1 0 3k
.op
.end
