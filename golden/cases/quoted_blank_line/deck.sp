* quoted_blank_line: a blank line inside a quoted R value that goes on on a + line
.param a=2k
v1 1 0 1
r7 1 0 'a

+ *5'
rc 1 0 1k
.op
.end
