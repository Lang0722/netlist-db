* end_quoted_arg: .end with a quoted word, then a second deck
v1 1 0 1
r1 1 0 1k
.op
.end 'x'
* end_quoted_arg: second deck
v2 2 0 1
r2 2 0 2k
.op
.end
