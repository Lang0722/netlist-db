* res_value_model: resistor value, then model name (R1 1 0 2k rmod)
.option list
.model rmod r
v1 1 0 1
R1 1 0 2k rmod
.op
.end
