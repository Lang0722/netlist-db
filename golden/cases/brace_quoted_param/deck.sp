* brace_quoted_param: {...} inside quotes in a .param value
.param a=2 p='{a}*2'
v1 1 0 1
R1 1 0 p
.op
.end
