* after_end_second_deck: first deck
v1 1 0 1
r1 1 0 1k
.op
.end
* after_end_second_deck: second deck
v2 2 0 1
r2 2 0 2k
.op
.end
