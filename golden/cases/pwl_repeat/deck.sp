* pwl_repeat: PWL repeat flag R after the closing parenthesis
.option list
V1 1 0 PWL(0 0.3 1n 1) R
r1 1 0 1k
.op
.end
