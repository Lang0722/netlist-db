* paren_blank_call: a blank line inside the parentheses of an unquoted function call in a .param value
.param p=max(1k,

+ 3k)
v1 1 0 1
rp 1 0 p
.op
.end
