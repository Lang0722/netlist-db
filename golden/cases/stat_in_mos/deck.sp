* rv_stat_in_mos: a statistical function in a MOSFET w= value
v1 1 0 1
m1 1 1 0 0 nch w='1u*agauss(1,0.1,3)' l=1u
.model nch nmos level=1
.op
.end
