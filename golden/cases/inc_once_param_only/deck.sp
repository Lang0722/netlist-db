* inc_once_param_only: one .include (only a .param), then a .param of the same name
.include 'params.inc'
.param pi=5k
v1 1 0 1
r1 1 0 pi
.op
.end
