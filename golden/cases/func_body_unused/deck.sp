* probe_func_body_unused: an unused top-level .param function whose body names kk, defined nowhere
.param f(x)='x*kk'
v1 1 0 1
r1 1 0 1k
.op
.end
