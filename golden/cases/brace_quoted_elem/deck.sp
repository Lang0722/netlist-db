* brace_quoted_elem: {...} inside quotes in an element value
.param a=2k
v1 1 0 1
R1 1 0 '{a}'
.op
.end
