* quoted_dollarline_elem: a $ comment line inside a quoted R value that goes on on a + line
.param a=2k
v1 1 0 1
r1 1 0 'a
$ a dollar comment line
+ *5'
rc 1 0 1k
.op
.end
