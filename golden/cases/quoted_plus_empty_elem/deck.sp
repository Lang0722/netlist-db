* quoted_plus_empty_elem: a + line with no text inside a quoted R value that goes on on a + line
.param a=2k
v1 1 0 1
r1 1 0 'a
+
+ *5'
rc 1 0 1k
.op
.end
