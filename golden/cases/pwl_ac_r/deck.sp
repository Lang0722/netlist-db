* pwl_ac_r: PWL, then AC 1 R (R in the place of the AC phase)
.option list
V1 1 0 PWL(0 0.3 1n 1) AC 1 R
r1 1 0 1k
.op
.end
