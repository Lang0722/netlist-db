* stat_nominal: statistical functions give their nominal value in .op
.param pa=agauss(1k,0.1k,3) pg=gauss(2k,0.1,3) pu=aunif(3k,0.1k) pn=unif(4k,0.1)
v1 1 0 1
ra 1 0 pa
rg 1 0 pg
ru 1 0 pu
rn 1 0 pn
.op
.end
