* pwl_td: PWL TD=1n after the closing parenthesis
.option list
V1 1 0 PWL(0 0.3 1n 1) TD=1n
r1 1 0 1k
.op
.end
