* pwl_repeat_key_only: PWL R=1n alone
.option list
V1 1 0 PWL(0 0.3 1n 1) R=1n
r1 1 0 1k
.op
.end
