* end_kv_arg: .end with a key=value word, then a second deck
v1 1 0 1
r1 1 0 1k
.op
.end x=1
* end_kv_arg: second deck
v2 2 0 1
r2 2 0 2k
.op
.end
