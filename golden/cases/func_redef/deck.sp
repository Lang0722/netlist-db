* func_redef: a .param function defined twice at the top level, used between (default parhier)
.param f(x)='x*2'
r1 1 0 'f(1)*1k'
.param f(x)='x*3'
v1 1 0 1
.op
.end
