* quoted_plus_pwl: a quoted PWL argument that goes on on a + line
.option list
v1 1 0 PWL(0 '0.3
+ *1' 1n 1)
v2 2 0 PWL(0 '0.3
+ *2' 1n 1)
r1 1 0 1k
r2 2 0 1k
.op
.end
