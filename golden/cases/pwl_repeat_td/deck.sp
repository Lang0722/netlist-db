* pwl_repeat_td: PWL R=0 TD=1n after the closing parenthesis
.option list
V1 1 0 PWL(0 0.3 1n 1) R=0 TD=1n
r1 1 0 1k
.op
.end
