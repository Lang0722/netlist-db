* p8_rcl_param_tc: a parameter name in the R value place, then bare numbers (.temp 125)
.temp 125
.param rval=2k
r1 1 0 rval 0.004
r2 2 0 rval
r3 3 0 rval 0.004 1e-5
v1 1 0 1
v2 2 0 1
v3 3 0 1
.op
.end
