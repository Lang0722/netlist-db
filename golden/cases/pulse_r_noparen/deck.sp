* pulse_r_noparen: PULSE without parentheses, then R
.option list
V1 1 0 PULSE 0 1 0 1n R
r1 1 0 1k
.op
.end
