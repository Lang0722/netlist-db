* paren_plus_call: an unquoted function call in a .param value that goes on on a + line
.param p=max(1k,
+ 3k)
v1 1 0 1
rp 1 0 p
.op
.end
