* src_order_ac_first: AC before DC on a V line
.option list
V1 1 0 AC 1 45 DC 0.7
r1 1 0 1k
.op
.end
