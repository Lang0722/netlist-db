* src_fn_dc_more: DC after a SIN function on a V line
.option list
V1 1 0 SIN(0 1 1meg) DC 0.7
r1 1 0 1k
.op
.end
