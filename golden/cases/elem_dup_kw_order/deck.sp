* elem_dup_kw_order: a positional resistor value after the keyword value
v3 3 0 1
R3 3 0 r=3k 1k
.op
.end
