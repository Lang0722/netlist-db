* pwl_repeat_key_bare: PWL R=1n, then a bare R
.option list
V1 1 0 PWL(0 0.3 1n 1) R=1n R
r1 1 0 1k
.op
.end
