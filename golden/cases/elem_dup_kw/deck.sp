* elem_dup_kw: a resistor value given twice (keyword twice; positional + keyword)
v1 1 0 1
v2 2 0 1
R1 1 0 r=1k r=2k
R2 2 0 1k r=3k
.op
.end
