* param_undef_unused: an unused top-level .param that names a parameter defined nowhere
.param a='b*2'
r1 1 0 1k
v1 1 0 1
.op
.end
