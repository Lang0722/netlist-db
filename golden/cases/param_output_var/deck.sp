* probe_param_vnode: an unused top-level .param whose text is an output variable
.param p='v(out)*2'
v1 out 0 1
r1 out 0 1k
.op
.end
