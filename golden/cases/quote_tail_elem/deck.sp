* quote_tail_elem: text after the closing quote of an R value
.option list
.param a=2k
v1 1 0 1
r1 1 0 'a' *2
rc 1 0 1k
.op
.end
